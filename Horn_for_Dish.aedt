# Ansys Electronics Desktop project, version 2023.1
materials:
  vacuum: permittivity=1

design HFSSDesign1 (HFSS, HFSS Hybrid Modal Network, model units mm)
variables:
  Offset = 0mm
  post_PhaseCenter_X = -0.067208295mm
  post_PhaseCenter_Y = 0.057798631mm
  post_PhaseCenter_Z = -20.642842mm  # optimise -100.0mm..100.0mm
geometry:
  Horn1 = component(Horn, 3D_Component_File_Path=<userlib>/3DComponents/Horn.a3dcomp, Frequency=5GHz, R_Horn=20mm)
  Horn1.move(TranslateVectorX=0mm TranslateVectorY=Offset TranslateVectorZ=0mm)
  Horn_1 [vacuum] = part_of(Horn1)
  pCap [pec] = part_of(Horn1)
  Horn_RadVol [vacuum] = part_of(Horn1)
  Horn1.rotate(RotateAxis=X RotateAngle=-90deg)
  coordinate_system RelativeCS1 = origin=(0mm, 0mm, post_PhaseCenter_Z) Euler Angle ZYZ phi=0deg theta=0deg psi=0deg
boundaries and excitations:
  Horn1_Rad1: FE-BI Objects=Horn_RadVol UseAdaptiveIE
  Horn1_Horn: Perfect E Faces=Horn_1.face(at (0, -20, -149.917), at (0, 46.7169, -59.9585))
  Horn1_1: Wave Port Faces=Horn_1.face(at (0, 0, -179.917)) WavePortType=Modal NumModes=2 UseLineModeAlignment Modes{Mode1{IntLine{(0, -20, -179.9169832) -> (0, 20, -179.9169832)} CharImp=Zpi} Mode2{IntLine{(-20, 0, -179.9169832) -> (20, 0, -179.9169832)} CharImp=Zpi}}
mesh:
  Horn1_Length1: LengthBased Faces=Horn_1.face(at (0, -20, -149.917), at (0, 46.7169, -59.9585)) NumMaxElem=10000
setups:
  5GHz: HfssDriven Frequency=5GHz MaxDeltaS=0.01 MaximumPasses=6 MinimumPasses=1 MinimumConvergedPasses=1 PercentRefinement=30 BasisOrder=1 PortAccuracy=0.1 DrivenSolverType="Domain Decomposition" IterativeResidual=1e-06 DDMSolverResidual=0.0001 IESolverType=ACA
source amplitudes:
  Horn1_1:1: 1W 0deg
  Horn1_1:2: 0W 0deg
optimetrics:
  OptimizationSetup1: Optimization disabled Optimizer="kDX ASO" AnalysisStopOptions{StopForNumIteration MaxNumIteration=80 MinNumIteration=10} CostFuncNormType=L2 Acceptable_Cost=0 Noise=1e-05 UpdateDesignWhenDone
    vary post_PhaseCenter_Z: Min=-100mm Max=100mm MinStep=0.02mm MaxStep=0.2mm MinFocus=-100mm MaxFocus=100mm start=0mm
    goal pk2pk(cang_deg(rEY)) <= 1e-08 weight 1 on 5GHz : LastAdaptive at Theta -10deg to 10deg, Phi 0deg, Freq 5GHz
radiation setups:
  Infinite Sphere1: Infinite Sphere Theta=-180deg..180deg step 2deg Phi=0deg..180deg step 2deg CoordSystem=RelativeCS1
